# Ansys Electronics Desktop project, version 2023.1
project variables:
  $antipad_d = 0.7mm
  $board_left_limit = -2mm
  $board_lower_limit = -2mm
  $board_right_limit = 2mm
  $board_upper_limit = 2mm
  $drill_tol_x = 0mm
  $drill_tol_y = 0mm
  $hole_d = 0.3mm
  $model_center_x = 0mm
  $model_center_y = 0mm
  $pad_d = 0.5mm
  $sg_via_angle = 0deg
  $sg_via_distance = 1mm
  $signal_in_clearance = 0.3mm
  $signal_in_gap = 0.2mm
  $signal_in_teardrop_width = 0.2mm
  $signal_in_width = 0.1mm
  $signal_out_clearance = 0.3mm
  $signal_out_gap = 0.25mm
  $signal_out_teardrop_width = 0.2mm
  $signal_out_width = 0.075mm
  $ss_via_distance = 1mm
materials:
  air: permittivity=1.0006 permeability=1.0000004
  copper: permittivity=1 permeability=0.999991 conductivity=58000000
  fr4_epoxy: permittivity=4.4 permeability=1 dielectric_loss_tangent=0.02
  pec: conductivity=1e+30
  solder_mask: permittivity=3.1 permeability=1 dielectric_loss_tangent=0.035
  vacuum: permittivity=1

design Cell_F55YG7 (HFSS 3D Layout)
nets:
  signal_n: port signal_in:T2, port signal_out:T2
  signal_p: port signal_in:T1, port signal_out:T1
ports:
  signal_in:T1, signal_in:T2: Properties{Reference=L2:GND:rect_4 Override_Impedance Impedance=50 Magnitude=0V Phase=0deg Renormalize_Impedence=50ohm Deembed_Distance=0mm Layer_Alignment=Upper Horizontal_Extent_Factor=8 Vertical_Extent_Factor=8 PEC_Launch_Width=0.01mm} Type=EdgePortCoupledStrip
  signal_out:T1, signal_out:T2: Properties{Reference=L5:GND:rect_12 Override_Impedance Impedance=50 Magnitude=0V Phase=0deg Renormalize_Impedence=50ohm Deembed_Distance=0mm Layer_Alignment=Lower Horizontal_Extent_Factor=8 Vertical_Extent_Factor=8 PEC_Launch_Width=0.01mm} Type=EdgePortCoupledStrip
setups:
  Setup1: SolveSetupType=HFSS PercentRefinementPerPass=30 MinNumberOfPasses=1 MinNumberOfConvergedPasses=1 Frequency=10GHz MeshSizeFactor=1.5 ViaNumSides=12 ViaMaterial=copper Style25DVia=Mesh
    sweep sweep1: LINC 1GHz 30GHz 30; SAbsError=0.005 ZoPercentError=1 PassivityTolerance=0.0001 MaxSolutions=250 InterpUseSMatrix InterpUsePortImpedance InterpUseFullBasis MinSolvedFreq=0 AutoSMatOnlySolve MinFreqSMatrixOnlySolve=1MHz MagMinThreshold=0.01 FreqSweepType=kInterpolating
reports:
  sdd11: dB(S(signal_in,signal_in)) vs Freq on Setup1 : sweep1
  scd21: dB(S(Comm_MDWAQN,signal_in)) vs Freq on Setup1 : sweep1
